** sch_path: /foss/designs/Spikcore/designs/libs/core_synapse_arr/synapse_arr.sch
.SUBCKT synapse_arr vdd vss vi ve vout_0 v_in_0 v_ctrl_0 vout_1 v_in_1 v_ctrl_1 v_in_2 vout_2 v_ctrl_2 vout_3 v_in_3 v_ctrl_3
+ vout_4 v_in_4 v_ctrl_4 vout_5 v_in_5 v_ctrl_5
*.PININFO vdd:B vss:B v_in_0:B vout_0:B v_in_1:B vout_1:B v_in_2:B vout_2:B v_in_3:B vout_3:B v_in_4:B vout_4:B vi:B ve:B v_in_5:B
*+ vout_5:B v_ctrl_0:B v_ctrl_1:B v_ctrl_2:B v_ctrl_3:B v_ctrl_4:B v_ctrl_5:B
x0 vdd v_in_0 ve v_ctrl_0 vout_0 vi vss synapse
x1 vdd v_in_1 ve v_ctrl_1 vout_1 vi vss synapse
x2 vdd v_in_2 ve v_ctrl_2 vout_2 vi vss synapse
x3 vdd v_in_3 ve v_ctrl_3 vout_3 vi vss synapse
x4 vdd v_in_4 ve v_ctrl_4 vout_4 vi vss synapse
x5 vdd v_in_5 ve v_ctrl_5 vout_5 vi vss synapse
.ENDS

* expanding   symbol:  designs/libs/core_synapse/synapse.sym # of pins=7
** sym_path: /foss/designs/Spikcore/designs/libs/core_synapse/synapse.sym
** sch_path: /foss/designs/Spikcore/designs/libs/core_synapse/synapse.sch
.SUBCKT synapse vdd v_in ve v_ctrl v_out vi vss
*.PININFO v_out:B v_ctrl:B ve:B vi:B v_in:B vdd:B vss:B
XM5 net2 net2 vdd vdd pfet_03v3 L=0.28u W=0.42u nf=1
XM1 net1 v_in vdd vdd pfet_03v3 L=0.28u W=0.42u nf=1
XM3 net1 v_in vss vss nfet_03v3 L=0.28u W=0.42u nf=1
XM4 net2 v_in net3 vss nfet_03v3 L=0.28u W=0.42u nf=1
XM6 net3 ve vss vss nfet_03v3 L=0.28u W=0.42u nf=1
XM7 net5 vi vdd vdd pfet_03v3 L=0.28u W=0.42u nf=1
XM8 net4 net1 net5 vdd pfet_03v3 L=0.28u W=0.42u nf=1
XM9 net4 net4 vss vss nfet_03v3 L=0.28u W=0.42u nf=1
XM2 net7 net2 vdd vdd pfet_03v3 L=0.28u W=2.8u nf=1
XM10 v_out v_ctrl net7 vdd pfet_03v3 L=0.28u W=2.8u nf=1
XM11 v_out v_ctrl net6 vss nfet_03v3 L=0.28u W=2u nf=1
XM12 net6 net4 vss vss nfet_03v3 L=0.28u W=1u nf=1
.ENDS
