* NGSPICE file created from synapse_arr.ext - technology: gf180mcuD

.subckt pfet$23$1 a_28_n136# w_n232_n142# a_94_0# a_n92_n2#
X0 a_94_0# a_28_n136# a_n92_n2# w_n232_n142# pfet_03v3 ad=0.2822p pd=2.18u as=0.2822p ps=2.18u w=0.42u l=0.28u
.ends

.subckt nfet$37$1 a_n84_n2# dw_n710_n726# a_30_n132# a_94_0# w_n710_n726#
X0 a_94_0# a_30_n132# a_n84_n2# w_n710_n726# nfet_03v3 ad=0.2646p pd=2.1u as=0.2646p ps=2.1u w=0.42u l=0.28u
.ends

.subckt nfet$36$1 dw_n710_n726# a_30_n132# a_n84_0# a_94_0# w_n710_n726#
X0 a_94_0# a_30_n132# a_n84_0# w_n710_n726# nfet_03v3 ad=1.22p pd=5.22u as=1.22p ps=5.22u w=2u l=0.28u
.ends

.subckt pfet$22$1 a_28_144# w_n232_n142# a_94_0# a_n92_n2#
X0 a_94_0# a_28_144# a_n92_n2# w_n232_n142# pfet_03v3 ad=0.2822p pd=2.18u as=0.2822p ps=2.18u w=0.42u l=0.28u
.ends

.subckt nfet$39$1 a_n84_n2# dw_n710_n652# a_94_0# a_30_144# w_n710_n652#
X0 a_94_0# a_30_144# a_n84_n2# w_n710_n652# nfet_03v3 ad=0.2646p pd=2.1u as=0.2646p ps=2.1u w=0.42u l=0.28u
.ends

.subckt pfet$21$1 a_28_n136# a_n92_0# a_94_0# w_n230_n138#
X0 a_94_0# a_28_n136# a_n92_0# w_n230_n138# pfet_03v3 ad=1.82p pd=6.9u as=1.82p ps=6.9u w=2.8u l=0.28u
.ends

.subckt nfet$38$1 dw_n710_n652# a_30_260# a_n84_0# a_94_0# w_n710_n652#
X0 a_94_0# a_30_260# a_n84_0# w_n710_n652# nfet_03v3 ad=0.61p pd=3.22u as=0.61p ps=3.22u w=1u l=0.28u
.ends

.subckt pfet$20$1 a_28_620# a_n92_0# a_94_0# w_n230_n138#
X0 a_94_0# a_28_620# a_n92_0# w_n230_n138# pfet_03v3 ad=1.82p pd=6.9u as=1.82p ps=6.9u w=2.8u l=0.28u
.ends

.subckt synapse vi v_ctrl v_in ve vdd v_out vss
Xpfet$23$1_0 vi vdd vdd m1_44_2533# pfet$23$1
Xnfet$37$1_2 m1_344_2455# nfet$39$1_0/dw_n710_n652# m1_344_2455# vss vss nfet$37$1
Xnfet$36$1_0 nfet$39$1_0/dw_n710_n652# v_ctrl v_out m1_2266_n82# vss nfet$36$1
Xpfet$22$1_0 v_in vdd vdd m1_856_n14# pfet$22$1
Xpfet$22$1_1 m1_856_n14# vdd m1_44_2533# m1_344_2455# pfet$22$1
Xnfet$39$1_0 m2_640_1617# nfet$39$1_0/dw_n710_n652# m1_1434_n778# v_in vss nfet$39$1
Xpfet$22$1_2 m2_640_1617# vdd vdd m2_640_1617# pfet$22$1
Xpfet$21$1_0 m2_640_1617# m1_1750_2493# vdd vdd pfet$21$1
Xnfet$38$1_0 nfet$39$1_0/dw_n710_n652# m1_344_2455# m1_2266_n82# vss vss nfet$38$1
Xpfet$20$1_0 v_ctrl v_out m1_1750_2493# vdd pfet$20$1
Xnfet$37$1_1 m1_856_n14# nfet$39$1_0/dw_n710_n652# v_in vss vss nfet$37$1
Xnfet$37$1_0 m1_1434_n778# nfet$39$1_0/dw_n710_n652# ve vss vss nfet$37$1
.ends

.subckt synapse_arr ve vi v_in_0 v_in_1 vout_1 v_in_2 vout_2 v_in_3 vout_3 v_in_4
+ vout_4 v_in_5 vout_5 vout_0 vss vdd v_ctrl_5 v_ctrl_4 v_ctrl_3 v_ctrl_2 v_ctrl_1
+ v_ctrl_0
Xsynapse_0 vi v_ctrl_0 v_in_0 ve vdd vout_0 vss synapse
Xsynapse_1 vi v_ctrl_1 v_in_1 ve vdd vout_1 vss synapse
Xsynapse_2 vi v_ctrl_4 v_in_4 ve vdd vout_4 vss synapse
Xsynapse_3 vi v_ctrl_5 v_in_5 ve vdd vout_5 vss synapse
Xsynapse_4 vi v_ctrl_2 v_in_2 ve vdd vout_2 vss synapse
Xsynapse_5 vi v_ctrl_3 v_in_3 ve vdd vout_3 vss synapse
.ends
